* Reset state: IO48 floating with a worst-case ~45k internal pull-down. R18 100k (old) vs 10k (rev 9).
.include models.inc
Vb boost 0 12.6
V3 v33 0 3.3
Rpd io48 0 45k
R17 io48 q4g 100
R18 q4g v33 {R18val}
M4 q4d q4g 0 0 N7002 W=1 L=1
R51 q11g q4d 100k
R52 q11g boost 100k
M11 rdr q11g boost boost P3401 W=1 L=1
Rrdr rdr 0 84
.param R18val=100k
.control
op
echo "R18 = 100k:"
print v(q4g) v(rdr)
alterparam R18val=10k
reset
op
echo "R18 = 10k:"
print v(q4g) v(rdr)
.endc
.end
