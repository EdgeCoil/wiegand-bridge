* Relay driver (rev 10): TCA9535 output 3.3 V -> R63 1k -> 2N7002 (R64 100k pull-down); SRD-05VDC coil 70 ohm from +5V; 1N4148W flyback
.include models.inc
.model D4148 D(Is=2.5n N=1.75 Rs=0.6 BV=75)
V5 v5 0 4.6
Vg drv 0 PULSE(0 3.3 1m 10u 10u 3m 10m)
R63 drv g 1k
R64 g 0 100k
M12 coil g 0 0 N7002 W=1 L=1
Lc v5 x 0.1
Rc x coil 70
D14 coil v5 D4148
.tran 1u 8m
.control
run
meas tran icoil_on FIND i(V5) AT=3.5m
meas tran vds_on FIND v(coil) AT=3.5m
meas tran vpeak_off MAX v(coil) FROM=4m TO=6m
.endc
.end
